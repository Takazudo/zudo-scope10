* zudo-scope10 P0 nominal DC/AC model. Ideal infinite-headroom buffers.
* This file is NOT a protection or op-amp stability model. ngspice was not run here.
VREF REF 0 3
VIN IN 0 DC 0 AC 1
RIN IN BIAS 1Meg
RREF REF BIAS 200k
RGND BIAS 0 249k
CONE BIAS 0 470p
EBUFFER1 BUF1 0 BIAS 0 1
RFILTER BUF1 LP2 4.7k
CTWO LP2 0 10n
EBUFFER2 OUT 0 LP2 0 1
.control
op
print v(BIAS) v(OUT)
ac dec 40 1 100000
write input-channel-ac.raw
quit
.endc
.end
